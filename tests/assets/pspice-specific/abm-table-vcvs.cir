PSpice ABM TABLE voltage source
VIN anode 0 DC 0
VREF cathode 0 DC 0
ET2 out 0 TABLE {V(anode,cathode)} = (0,0) (30,1)
RLOAD out 0 10k
.DC VIN 0 30 1
.PROBE V(out)
.END
