PSpice VECTOR digital output
VCLK clock 0 PULSE(0 5 0 1ns 1ns 50ns 100ns)
RCLK clock 0 1meg
.TRAN 1ns 400ns
.VECTOR 1 CLOCK SIGNAMES=SYSCLK
.VECTOR 4 DATA3 DATA2 DATA1 DATA0
.END
