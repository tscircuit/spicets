PSpice ABM FREQ voltage source
VIN in 0 AC 1
ELOWPASS out 0 FREQ {V(in)} = DB (0,0,0) (5kHz,0,0) (6kHz,-60,0) DELAY=3.2ms
RLOAD out 0 10k
.AC DEC 20 10 100k
.PROBE V(out)
.END
